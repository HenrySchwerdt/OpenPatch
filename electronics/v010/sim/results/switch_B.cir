* v010 switch + OC, case B
.param vcell=4.2 rint=3.0
Vcell vc 0 {vcell}
Rint vc vbat {rint}
C5 vbat 0 10u
Cbulk vmot 0 32u
C24 vraw 0 10u
* gate drive: LATCH_Q, MCU_EN, DOCKED_H, DIR_REV (3.3 V logic)
Vlatch latch 0 PWL(0 0 2m 0 2.001m 3.3)
Vmcuen mcuen 0 PWL(0 0 5m 0 5.001m 3.3)
Vdock dockedh 0 3.3
Vdir dirrev 0 0
.model PM pmos level=1 vto=-1.0 kp=8 lambda=0.02
.model NM nmos level=1 vto=1.6 kp=0.07 lambda=0.02
* series P-FETs (second one shares PGATE); case F/G replace one by a short
M4 vmota pgate vbat vbat PM
M15 vraw pgate vmota vmota PM
Cgs4 pgate vbat 600p
R9 vbat pgate 100k
R10 vbat pgate 100k
C11 pgate vbat 100n
R11 pgate chtop 10k
M5 chtop latch mid1 mid1 NM
M8 mid1 mcuen mid2 mid2 NM
M13 mid2 ocok mid2a mid2a NM
* H15: interlock leg = DOCKED XOR DIR_REV (branch 1: docked AND forward, branch 2: undocked AND reverse)
Bnot docknot 0 V=3.3-v(dockedh)
Bfwd fwd 0 V=3.3-v(dirrev)
M6 mid2a dockedh xa xa NM
M21 xa fwd 0 0 NM
M10 mid2a docknot xb xb NM
M22 xb dirrev 0 0 NM
* bleeder (turns on when PGATE is high)
M17 bldn pgate 0 0 NM
Rb1 vmot bldn 100
Rb2 vmot bldn 100
* shunt + INA180A1 (supplied from VRAW) + 10k/10n blanking
Rbyp vraw vpre 0.01
Rsh vpre vmot 0.22
Bina inaraw 0 V=min(max(20*(v(vpre)-v(vmot)),0),max(v(vraw)-0.05,0))
Rina inaraw inaout 1k
Cina inaout 0 0.5n
Rpd inaout 0 100k
Roc inaout ocin 10k
Coc ocin 0 10n
* reference 3.3 V * 100k/110k... (R49 100k, R50+R51 = 110k)
Vrail v3v3 0 3.3
Rr1 v3v3 ocref 100k
Rr2 ocref 0 110k
* comparator (TLV7011): out high when ocin > ocref
Bcmp cmpraw 0 V=3.3*(0.5+0.5*tanh((v(ocin)-v(ocref))*200))
Rcmp cmpraw ocmp 100
Ccmp ocmp 0 5p
* OC_CLR_N: R54 100k from MCU_EN, C30 100n, diode D5 discharges when MCU_EN falls
R54 mcuen clrn 100k
C30 clrn 0 100n
.model DD d(is=1e-9 n=1.8 rs=10)
D5 clrn mcuen DD
* OC latch: lat node = Q (trip). set when ocmp high, cleared when clrn low
.model SW sw(vt=1.65 vh=0.1 ron=10 roff=1e12)
Clat lat 0 1n IC=0
Rlat lat 0 1e9
Bset sset 0 V=v(ocmp)
Bclr sclr 0 V=3.3-v(clrn)
Sset v3v3 lat sset 0 SW
Sclr lat 0 sclr 0 SW
Bocok ocok 0 V=3.3*(1-0.5*(1+tanh((v(lat)-1.65)*50)))
* motor: two phases, 26.5+2.3 ohm each, chopper limits each phase to 160 mA; optional bridge short
Bmot vmot 0 I=2*min(0.16, max(v(vmot),0)/28.8) + (time>150m ? v(vmot)/4 : 0)
.ic v(lat)=0 v(vmot)=0 v(clrn)=0 v(pgate)=4.2 v(vbat)=4.2 v(vc)=4.2
.tran 20u 400m uic
.control
set noaskquit
run
wrdata /home/user/ai-insulin-pump/.claude/worktrees/agent-a67e2538bfadd5ced/electronics/v010/sim/results/switch_B.csv v(vbat) v(vmot) v(vraw) v(pgate) v(ocok) v(inaout) v(ocmp) i(Vcell)
.endc
.end
